ADE simulation setup
Test EE477P_MULT4_1: EE477P/MULT4/schematic, simulator spectre
  Models: /home/viterbi/01/ee577/CDS_GPDK45/gpdk045_v_5_0/gpdk045/../models/spectre/gpdk045.scs[mc]
  Temperature: 27
  Files: vectors /home/viterbi/03/cchatela/work_gpdk045/mult.vec
  Stimulus VSS: voltage dc dc=0
  Stimulus VDD: voltage dc dc=1
  Analysis tran: stop=82n
  Signals: /A<0>, /A<1>, /A<2>, /A<3>, /B<0>, /B<1>, /B<2>, /B<3>, /Z<0>, /Z<1>, /Z<2>, /Z<3>, /Z<4>, /Z<5>, /Z<6>, /Z<7>
Run mode: Single Run, Sweeps and Corners
