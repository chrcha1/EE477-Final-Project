ADE simulation setup
Run mode: Single Run, Sweeps and Corners
Tests:
  EE477P_MULT4_1: EE477P/MULT4/schematic, simulator spectre
